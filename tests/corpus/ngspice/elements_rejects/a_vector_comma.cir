M17 reject
a1 [in, in] out sum
.model sum summer
.end
