M17 reject
N1 a b rmod off
.model rmod r2_cmc
.end
