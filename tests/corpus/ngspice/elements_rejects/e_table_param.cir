.title KiCad schematic
* reject: a parameter in a TABLE point; ngspice reads some forms wrongly (decision 0017 item 4)
.op
.param K=4.4
.control
  run
  print v(/VX) v(/OUT)
.endc
R1 /OUT GND 1k
R5 Net-_R5-Pad1_ /VX 1k
V1 Net-_R5-Pad1_ GND DC 2
R6 /VX GND 1k
R2 a GND 100
E1 /OUT a TABLE {v(/VX)} = (0, 0) (2, {K})
.end
