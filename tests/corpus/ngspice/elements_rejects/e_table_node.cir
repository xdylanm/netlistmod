.title KiCad schematic
* reject: a net named table; ngspice reads it as the keyword (decision 0017 item 5)
.op
.control
  run
  print v(/VX) v(/OUT)
.endc
R1 /OUT GND 1k
R5 Net-_R5-Pad1_ /VX 1k
V1 Net-_R5-Pad1_ GND DC 2
R6 /VX GND 1k
R2 table GND 100
E1 /OUT table /VX GND 2.2
.end
