.title KiCad schematic
* reject: POLY(2) with one node pair; ngspice stops
.op
.control
  run
  print v(/VX) v(/OUT)
.endc
R1 /OUT GND 1k
R5 Net-_R5-Pad1_ /VX 1k
V1 Net-_R5-Pad1_ GND DC 2
R6 /VX GND 1k
R2 a GND 100
E1 /OUT a POLY(2) /VX GND 0 2.2
.end
