.title KiCad schematic
* reject: value after the output nodes is the keyword, not the node; ngspice stops
.op
.control
  run
  print v(/VX) v(/OUT)
.endc
R1 /OUT GND 1k
R5 Net-_R5-Pad1_ /VX 1k
V1 Net-_R5-Pad1_ GND DC 2
R6 /VX GND 1k
R2 a GND 100
Rv value GND 1k
E1 /OUT a value GND 2.2
.end
