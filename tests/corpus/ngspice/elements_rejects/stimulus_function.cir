title
VIN 3 0 PULSE(-1 1 2NS 2NS 2NS 50NS 100NS 5)
.end
