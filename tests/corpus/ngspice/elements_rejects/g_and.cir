.title KiCad schematic
* reject: a gate on G; ngspice stops (decision 0017 item 4)
.op
.control
  run
  print v(/VX) v(/OUT)
.endc
R1 /OUT GND 1k
G1 /OUT GND and(2) /VX GND /VX2 GND (0.5, 0) (0.9, 0.002)
V1 Net-_R5-Pad1_ GND DC 2
R5 Net-_R5-Pad1_ /VX 1k
R6 /VX GND 1k
R2 Net-_R5-Pad1_ /VX2 1.5k
R3 /VX2 GND 470
.end
