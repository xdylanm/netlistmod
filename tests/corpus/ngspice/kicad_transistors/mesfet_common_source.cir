MESFET common-source stage, authored for the M13 corpus
.model zm NMF level=1 vto=-1.3 beta=0.05 lambda=0.03 alpha=3
V1 vdd 0 DC 5
V2 in 0 DC -0.5 SIN( -0.5 0.1 1meg 0 0 0 ) AC 1
RD vdd out 220
Z1 out in 0 zm 2 off
Z2 out2 in 0 zm ic=2,-0.5
RD2 vdd out2 220
.tran 10n 5u uic
.end
