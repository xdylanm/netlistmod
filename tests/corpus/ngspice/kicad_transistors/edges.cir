.title KiCad schematic
.include "jellybean.lib"
.tran 100n 1m
VIN /IN GND DC 0 SIN( -2 5 10k 0 0 0 ) AC 1
.control
  run
  wrdata out_edges.txt v(/IN) v(/SHIFTED) v(/NEG_EDGE_PULSE) v(/POS_EDGE_PULSE) v(/PULSE) v(/NPULSE)
.endc
RFB1 Net-_D3-K_ +12V 10
RFB2 Net-_D4-A_ -12V 10
D4 Net-_D4-A_ /VBUS_-12 B140_OJ
D3 /VBUS_+12 Net-_D3-K_ B140_OJ
C6 GND -12V 100n
C5 +12V GND 100n
XU2 /NEG_EDGE_PULSE /NEG_EDGE_PULSE Net-_Q4-C_ +12V Net-_U2B-+_ Net-_U2B--_ /NPULSE /PULSE /PULSE Net-_Q2-C_ -12V Net-_Q5-C_ /POS_EDGE_PULSE /POS_EDGE_PULSE TL074_OJ
XU1 Net-_R5-Pad1_ Net-_U1A--_ GND -12V GND Net-_U1B--_ /SHIFTED +12V TL072_OJ
C9 +12V GND 100n
C10 GND -12V 100n
C12 GND -12V 10u
C11 +12V GND 10u
C7 +12V GND 100n
C8 GND -12V 100n
R3 Net-_U1A--_ /IN 100k
R4 Net-_U1A--_ Net-_R4-Pad2_ 100k
R1 Net-_R1-Pad1_ +12V 10k
XRV1 Net-_R2-Pad2_ Net-_R4-Pad2_ Net-_R1-Pad1_ POT_OJ R=100k POS=0.6
R5 Net-_R5-Pad1_ Net-_U1A--_ 100k
R2 -12V Net-_R2-Pad2_ 10k
R6 Net-_U1B--_ Net-_R5-Pad1_ 100k
V3 +5V GND DC 5
V2 GND /VBUS_-12 DC 12
V1 /VBUS_+12 GND DC 12
R8 Net-_D1-K_ /SHIFTED 10k
D1 GND Net-_D1-K_ 1N4148_OJ
R9 Net-_J2-PadT_ /SHIFTED 1k
Q1 Net-_Q1-C_ Net-_D1-K_ Net-_Q1-E_ BC547B_OJ
Q2 Net-_Q2-C_ Net-_Q1-C_ Net-_Q1-E_ BC547B_OJ
R10 Net-_Q1-C_ +5V 10k
R11 Net-_Q2-C_ +5V 10k
R7 /SHIFTED Net-_U1B--_ 100k
R12 GND Net-_Q1-E_ 22
R15 Net-_Q3-B_ /PULSE 10k
Q3 Net-_Q3-C_ Net-_Q3-B_ GND BC547B_OJ
R21 Net-_Q4-B_ +5V 100k
C1 Net-_C1-Pad1_ Net-_Q4-B_ 22n
R17 Net-_C1-Pad1_ /PULSE 10k
R28 Net-_J5-PadT_ /POS_EDGE_PULSE 1k
R27 Net-_J6-PadT_ /NEG_EDGE_PULSE 1k
Q5 Net-_Q5-C_ Net-_Q5-B_ GND BC547B_OJ
R25 Net-_Q5-C_ +5V 10k
R22 Net-_Q5-B_ +5V 100k
R23 Net-_Q4-C_ +5V 10k
R24 /NPULSE Net-_U2B--_ 100k
R26 Net-_J4-PadT_ /NPULSE 1k
Q4 Net-_Q4-C_ Net-_Q4-B_ GND BC547B_OJ
C2 Net-_Q3-C_ Net-_Q5-B_ 22n
R20 Net-_Q3-C_ +5V 10k
R16 Net-_J3-PadT_ /PULSE 1k
R18 GND Net-_D2-K_ 4.7k
D2 /PULSE Net-_D2-K_ 1N4148_OJ
R13 Net-_U2B-+_ +5V 100k
R14 GND Net-_U2B-+_ 100k
R19 Net-_U2B--_ /PULSE 100k

.end
