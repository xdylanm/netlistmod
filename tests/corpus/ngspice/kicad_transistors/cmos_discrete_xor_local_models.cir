.title KiCad schematic
* 2N7000_OJ: copied from openjellybean 0.5.0 (https://github.com/xdylanm/openjellybean), MIT;
* Copyright (c) 2026 openjellybean contributors.
.model 2N7000_OJ VDMOS(VTO=2.0 KP=0.3 LAMBDA=0.01 RD=0.6 RS=0.1 RG=10
+ CGS=16p CGDMAX=20p CGDMIN=3p A=0.5
+ CJO=40p VJ=0.75 M=0.5 IS=1e-13 N=1.1 RB=0.2 BV=60 IBV=10u TT=20n)
* BS250_OJ: copied from openjellybean 0.5.0 (https://github.com/xdylanm/openjellybean), MIT;
* Copyright (c) 2026 openjellybean contributors.
.model BS250_OJ VDMOS(pchan VTO=-2.1 KP=0.02 LAMBDA=0.01 RD=1.8 RS=0.2 RG=10
+ CGS=25p CGDMAX=21p CGDMIN=3.7p A=0.5
+ CJO=57p VJ=0.75 M=0.5 IS=1e-13 N=1.1 RB=0.5 BV=45 IBV=10u TT=30n)
.tran 1n 4u
.control
  run
  wrdata output_xor.txt v(/A) v(/B) v(/OUT)
.endc
MQ8 Net-_Q4-D_ Net-_Q1-D_ /OUT 2N7000_OJ
MQ4 Net-_Q4-D_ Net-_Q1-D_ /B 2N7000_OJ
MQ2 Net-_Q1-D_ /A Net-_Q2-S_ BS250_OJ
MQ3 /B /A Net-_Q3-S_ BS250_OJ
MQ7 /OUT /A Net-_Q3-S_ BS250_OJ
R1 Net-_Q2-S_ Net-_R1-Pad2_ 10
V1 Net-_R1-Pad2_ GND DC 5
MQ1 Net-_Q1-D_ /A GND 2N7000_OJ
MQ9 Net-_Q5-D_ /B /A BS250_OJ
MQ5 Net-_Q5-D_ /B /OUT BS250_OJ
V2 /A GND PULSE( 0 5 2n 20n 20n 250n 500n )
V3 /B GND PULSE( 0 5 2n 20n 20n 500n 1u )
C1 /OUT GND 220p
MQ6 /OUT /B Net-_Q10-S_ 2N7000_OJ
R2 GND /OUT 100k
MQ10 Net-_Q1-D_ /B Net-_Q10-S_ 2N7000_OJ
.end
