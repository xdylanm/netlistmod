.title KiCad schematic
.include "jellybean.lib"
.op
.tran 100n 30u
V2 /IN GND DC 2.5 SIN( 2.5 1 100k 0 0 0 ) AC 1
R1 /IN Net-_Q2-B_ 10k
V1 Net-_Q1-C_ GND DC 5
R2 Net-_Q1-B_ Net-_Q1-C_ 1k
Q2 GND Net-_Q2-B_ Net-_Q1-B_ BC557B_OJ dtemp=5
Q1 Net-_Q1-C_ Net-_Q1-B_ /OUT BC547B_OJ temp=50 m=2
R3 GND /OUT 1k
.control
  run
  wrdata output_follower.txt v(/IN) v(/OUT)
.endc
.end
