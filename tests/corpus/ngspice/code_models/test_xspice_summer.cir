XSPICE summers with vector ports and vector parameters (netlistmod M17 base)
.param g2=1
V1 in1 0 1
V2 in2 0 2
a1 [in1 in2] out1 sum1
a2 %v[in1 %vd(in2 in1)] out2 sum2
Rl1 out1 0 1k
Rl2 out2 0 1k
.model sum1 summer(in_offset=[0 0] in_gain=[2.0 {g2}]
+ out_gain=1 out_offset=0)
.model sum2 summer(in_gain=[1 1])
.op
.end
