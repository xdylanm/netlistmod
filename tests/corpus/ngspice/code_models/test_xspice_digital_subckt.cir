XSPICE digital gates and a flip-flop in a subcircuit, with NULL in capitals (netlistmod M17 variant)
V1 in 0 pulse(0 1 0 1n 1n 50n 100n)
V2 clkin 0 pulse(0 1 25n 1n 1n 25n 50n)
X1 in clkin out1 out2 out3 logic
Rl1 out1 0 1k
Rl2 out2 0 1k
Rl3 out3 0 1k
.subckt logic in clkin out1 out2 out3
a1 [in clkin] [d clk] adc
a2 d dn inv1
a3 [~d dn] dnand nand1
a4 d clk NULL Null q qb ff
a5 [q qb dnand] [out1 out2 out3] dac
.model adc adc_bridge(in_low=0.3 in_high=0.7)
.model dac dac_bridge(out_low=0 out_high=1)
.model inv1 d_inverter(rise_delay=1n fall_delay=1n)
.model nand1 d_nand(rise_delay=1n fall_delay=1n)
.model ff d_dff(clk_delay=1n set_delay=1n reset_delay=1n)
.ends logic
.tran 1n 400n
.end
