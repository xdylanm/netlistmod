Golden mixed endings
.include "h.cir"
.param k=1
V1 in 0 3
R1 in out 1k
R2 out 0 1k
.op
.save v(out)
.end
