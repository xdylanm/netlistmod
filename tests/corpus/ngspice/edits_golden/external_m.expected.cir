source function EXTERNAL
VX 1 0 dc 0 external m=2
R1 1 0 1k
.op
.end
