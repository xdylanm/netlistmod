M17 golden input: code models and OSDI devices (netlistmod)
V1 in 0 1
Vs in x 0
Rx x 0 1k
a1 in out1 amp
a2 [in x] out2 sum
a3 in out3 lim
N1 out1 0 rmod l=20u
Rl1 out1 0 1k
Rl2 out2 0 1k
Rl3 out3 0 1k
.model amp gain(gain=5)
.model amp2 gain(gain=2)
.model sum summer(in_gain=[1 ; one per input
+ 1] out_gain=1)
.model lim limit(gain=5 out_lower_limit=0 out_upper_limit=3)
.model rmod r2_cmc(rsh=200)
.model rmod2 r2_cmc(rsh=100)
.control
pre_osdi r2_cmc.osdi
.endc
.op
.end
