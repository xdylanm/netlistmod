Golden mixed endings
V1 in 0 3
R1 in out 1k
R2 out 0 1k
.op
.end
