nonlinear edits (M15b)
V1 in 0 2
R1 in vx 1k
R2 vx 0 2k
Vs vx vs 0 ; sense
R3 vs 0 1k
.param k=2
E1 eo 0 TABLE {2*v(vx)} = (0,0) (2,5)
R4 eo 0 1k
E2 ep 0 TABLE {v(vx)} = (0 0) (2 5)
R5 ep 0 1k
E3 eq 0 vx 0 TABLE = (0, 0, 1, 2, 2, 4)
R6 eq 0 1k
G1 0 gt TABLE {v(vx)} = (0, 0) (1, 1m) (2, 5m) m=2
R7 gt 0 1k
E4 er 0 FREQ {v(vx)}= DB (1, 6.02, 0) (1e9, 6.02, 0) ; freq
R8 er 0 1k
E5 es 0 and(2) vx 0 vx 0 (0.5, 0) (0.9, 2) ; gate
R9 es 0 1k
E6 et 0 POLY(1) vx 0 0 2
R10 et 0 1k
F1 0 fp POLY(2) Vs Vs 0 1 1 m=2 ; two sources
R11 fp 0 1k
H1 hp 0 POLY(1) Vs 0 2k
R12 hp 0 1k
.op
.end
