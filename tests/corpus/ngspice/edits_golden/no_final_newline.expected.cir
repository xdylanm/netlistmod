Golden without a final newline
V1 in 0 3
R1 in 0 2k
.op
.end
