ac probe
V1 in 0 DC 0 AC 1
R1 in out 1k
C1 out 0 1u
.ac lin 3 100 300
.end
