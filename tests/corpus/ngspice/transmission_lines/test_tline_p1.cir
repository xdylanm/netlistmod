.title KiCad schematic
.model __P1 CPL R=0.1 L=5e-07 G=0 C=2e-10 length=1
R2 GND Net-_C1-Pad1_ 50
C1 Net-_C1-Pad1_ GND 22p
V1 Net-_R1-Pad2_ GND DC 0.1 SIN( 0.1 1 100Meg 0 0 0 ) AC 1
R1 Net-_R1-Pad1_ Net-_R1-Pad2_ 50
PT1 Net-_R1-Pad1_ GND Net-_C1-Pad1_ GND __P1 len=1
.end
