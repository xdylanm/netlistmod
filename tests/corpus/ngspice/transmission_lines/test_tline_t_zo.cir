.title KiCad schematic
.model __T1 LTRA( r=0 l=5e-07 g=0 c=2e-10 len=1 )
R2 GND Net-_C1-Pad1_ 50
C1 Net-_C1-Pad1_ GND 22p
V1 Net-_R1-Pad2_ GND DC 0.1 SIN( 0.1 1 100Meg 0 0 0 ) AC 1
R1 Net-_R1-Pad1_ Net-_R1-Pad2_ 50
TT1 Net-_R1-Pad1_ GND Net-_C1-Pad1_ GND Zo=50 TD=5n
.end
