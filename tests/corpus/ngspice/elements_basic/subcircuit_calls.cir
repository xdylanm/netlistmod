M3 subcircuit calls
X1 2 4 17 3 1 MULTI
X2 input output myfilter rval=1k cval=1n
X3 a b sub m=2 file="table.txt"
.end
