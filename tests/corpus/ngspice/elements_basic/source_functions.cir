source functions, every form of the manual that ngspice 47 runs here
VIN 3 0 PULSE(-1 1 2NS 2NS 2NS 50NS 100NS 5)
RIN 3 0 1k
V2 2 0 DC 1 SIN(0 1
+ 1MEG) AC 1 45 ; continued
R2 2 0 1k
V4 4 0 EXP(-4 -1 2NS 30NS 60NS 40NS)
R4 4 0 1k
V5 5 0 PWL(0 -7 10NS -7 11NS -3 17NS -3 18NS -7 50NS -7)
+ r=0 td=15NS
R5 5 0 1k
V6 6 0 SFFM(0 2 20 45 1k 1m 0 0)
R6 6 0 1k
V7 7 0 AM(0.5 2 1.8 20K 5MEG 1m)
R7 7 0 1k
V8 8 0 0 DISTOF1 0.1 -90.0
R8 8 0 1k
V9 9 0 DISTOF2 0.01
R9 9 0 1k
V10 10 0 dc 0 ac 1 portnum 1 z0 100
R10 10 0 1k
V11 11 0 dc 0 ac 1 portnum 2 z0=50
R11 11 0 1k
V12 12 0 SINE(0 1 1k)
R12 12 0 1k
ISRC 23 0 AC 0.333 45.0 SFFM(0 1 10K 5 1K)
R23 23 0 1k
.tran 1n 10n
.end
