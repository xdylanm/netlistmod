M4 reject
V1 in 0 DC 1
.ac dec 10 1
.end
