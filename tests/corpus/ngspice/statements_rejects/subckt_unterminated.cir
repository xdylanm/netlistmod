M4 reject
V1 in 0 DC 1
.subckt div a b
R1 a b 1k
.end
