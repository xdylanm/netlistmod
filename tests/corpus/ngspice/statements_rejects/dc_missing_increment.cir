M4 reject
V1 in 0 DC 1
.dc VIN 0 5
.end
