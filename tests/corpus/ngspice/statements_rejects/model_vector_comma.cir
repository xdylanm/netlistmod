M17 reject
.model sum summer(in_gain=[2.0, 1.0])
.end
