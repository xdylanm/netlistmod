M4 reject
V1 in 0 DC 1
.subckt div a 0
R1 a 0 1k
.ends
.end
