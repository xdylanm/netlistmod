M4 reject
V1 in 0 DC 1
.ac log 10 1 1k
.end
