M4 reject
V1 in 0 DC 1
.param a=1k
.param c = a
.end
