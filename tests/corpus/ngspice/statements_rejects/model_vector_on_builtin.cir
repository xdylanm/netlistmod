M17 reject
.model dm d(is=[1e-14 2e-14])
.end
