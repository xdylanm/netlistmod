M4 reject
V1 in 0 DC 1
.subckt div
.ends
.end
