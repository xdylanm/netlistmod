.title KiCad schematic
V1 /vin 0 DC 0 AC 1
C1 /vout 0 2.2u
R1 /vin /vout 10k
.end
