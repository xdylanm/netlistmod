RC low-pass filter
V1 in 0 DC 0 AC 1
R1 in out {rf}
C1 out 0 {cf}
.param rf=1k cf=1u
.ac dec 10 1 1meg
.end
