diode clamp
V1 in 0 DC 5
R1 in out 1k
D1 out 0 DCLAMP
D2 0 out dclamp off
.model DClamp D is=1e-14 n=1.05
.op
.end
