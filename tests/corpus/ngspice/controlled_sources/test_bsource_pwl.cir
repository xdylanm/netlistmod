.title KiCad schematic
* variant: the pwl function (manual 5.1.4)
.op
.control
  run
  print v(/VX) v(/OUT)
.endc
R1 /OUT GND 1k
R5 Net-_R5-Pad1_ /VX 1k
V1 Net-_R5-Pad1_ GND DC 2
R6 /VX GND 1k
B1 /OUT GND V = pwl(v(/VX), 0,0, 1,2, 2,4)
.end
