.title KiCad schematic
* variant: half the transconductance with m=2 (manual 4.2.1)
.op
.control
  run
  print v(/VX) v(/OUT)
.endc
R1 /OUT GND 1k
G1 /OUT GND /VX /VX2 -0.00097 m=2
V1 Net-_R5-Pad1_ GND DC 2
R5 Net-_R5-Pad1_ /VX 1k
R6 /VX GND 1k
R2 Net-_R5-Pad1_ /VX2 1.5k
R3 /VX2 GND 470
.end
