.title KiCad schematic
* variant: cur= with m= (manual 5.3.1)
.op
.control
  run
  print v(/VX) v(/OUT)
.endc
R1 /OUT GND 1k
G1 /OUT GND cur='-0.00097*v(/VX,/VX2)' m=2
V1 Net-_R5-Pad1_ GND DC 2
R5 Net-_R5-Pad1_ /VX 1k
R6 /VX GND 1k
R2 Net-_R5-Pad1_ /VX2 1.5k
R3 /VX2 GND 470
.end
