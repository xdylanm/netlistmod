.title KiCad schematic
* variant: POLY(2) with two controlling sources, and m= (manual 5.5.2, 4.2.1)
.op
.control
  run
  print v(/VX) v(/OUT)
.endc
.param K=2.2
R1 /OUT GND 1k
F1 /OUT GND POLY(2) V1 V1 0 1.1 1.1 m=2
V1 Net-_R5-Pad1_ GND DC 2
R5 Net-_R5-Pad1_ /VX 1k
R6 /VX GND 1k
.end
