.title KiCad schematic
* variant: FREQ, an XSPICE form (manual 5.2.6)
.op
.control
  run
  print v(/VX) v(/OUT)
.endc
R1 /OUT GND 1k
R5 Net-_R5-Pad1_ /VX 1k
V1 Net-_R5-Pad1_ GND DC 2
R6 /VX GND 1k
R2 a GND 100
E1 /OUT a FREQ {v(/VX)}= DB (1, 6.85, 0) (1e9, 6.85, 0)
.end
