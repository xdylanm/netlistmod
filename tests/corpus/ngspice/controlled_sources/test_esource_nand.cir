.title KiCad schematic
* variant: nand(2), an XSPICE form (manual 5.2.7)
.op
.control
  run
  print v(/VX) v(/OUT)
.endc
R1 /OUT GND 1k
R5 Net-_R5-Pad1_ /VX 1k
V1 Net-_R5-Pad1_ GND DC 2
R6 /VX GND 1k
R2 a GND 100
E1 /OUT a nand(2) /VX GND /VX GND (0.5, 0) (0.9, 2.2)
.end
