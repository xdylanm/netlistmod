.title KiCad schematic
* variant: FREQ with the manual's layout, a blank after the first parenthesis (decision 0017 item 4)
.op
.control
  run
  print v(/VX) v(/OUT)
.endc
R1 /OUT GND 1k
E1 /OUT GND FREQ {v(/VX)}= DB
+( 1.000000e+07Hz, 6.85, 0)
+(1.000000e+08Hz, 6.85, 0)
+(1.000000e+09Hz, 6.85, 0)
V1 Net-_R5-Pad1_ GND DC 2
R5 Net-_R5-Pad1_ /VX 1k
R6 /VX GND 1k
R2 Net-_R5-Pad1_ /VX2 1.5k
R3 /VX2 GND 470
.end
