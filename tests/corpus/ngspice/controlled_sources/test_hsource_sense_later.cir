.title KiCad schematic
* variant: the controlling source is a 0 V sense source written after H
.op
.control
  run
  print v(/VX) v(/OUT)
.endc
R1 /OUT GND 1k
H1 /OUT GND Vsense 2.2k
V1 Net-_R5-Pad1_ GND DC 2
R5 Net-_R5-Pad1_ /VX 1k
Vsense /VX vxi 0
R6 vxi GND 1k
.end
