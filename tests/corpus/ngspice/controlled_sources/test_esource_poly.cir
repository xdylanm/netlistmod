.title KiCad schematic
* variant: POLY(1) (manual 5.5.1)
.op
.control
  run
  print v(/VX) v(/OUT)
.endc
R1 /OUT GND 1k
R5 Net-_R5-Pad1_ /VX 1k
V1 Net-_R5-Pad1_ GND DC 2
R6 /VX GND 1k
R2 a GND 100
E1 /OUT a POLY(1) /VX GND 0 2.2
.end
