.title KiCad schematic
* loads with UNRESOLVED_ELEMENT: no such source; both stop
.op
.control
  run
  print v(/VX) v(/OUT)
.endc
.param K=2.2
R1 /OUT GND 1k
F1 /OUT GND Vmissing {K}
V1 Net-_R5-Pad1_ GND DC 2
R5 Net-_R5-Pad1_ /VX 1k
R6 /VX GND 1k
.end
