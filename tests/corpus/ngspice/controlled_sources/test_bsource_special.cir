.title KiCad schematic
* variant: the special variables time, temper and hertz (manual 5.1.2)
.op
.control
  run
  print v(/VX) v(/OUT)
.endc
R1 /OUT GND 1k
R5 Net-_R5-Pad1_ /VX 1k
V1 Net-_R5-Pad1_ GND DC 2
R6 /VX GND 1k
B1 /OUT GND V=2*v(/VX)+time+0*temper+0*hertz
.end
