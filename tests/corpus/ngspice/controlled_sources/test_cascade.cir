.title KiCad schematic
* variant: all six letters in one circuit, F, H and W sensing one source
.op
.control
  run
  print v(/VX) v(/OUT)
.endc
R1 /OUT GND 1k
R5 Net-_R5-Pad1_ /VX 1k
V1 Net-_R5-Pad1_ GND DC 2
R6 /VX GND 1k
E1 /OUT a /VX GND 2.2
Vsense a amid 0
Ra amid GND 1
H1 hout GND Vsense 1k
Rh hout GND 1k
G1 gout GND hout GND 1m
Rg gout GND 1k
F1 fout GND Vsense 2
Rf fout GND 1k
.model sw1 SW vt=0.5 ron=1 roff=1Meg
S1 sout GND gout GND sw1 off
Rs sout /VX 1k
.model cs1 CSW it=1m ron=1 roff=1Meg
W1 wout GND Vsense cs1
Rw wout /VX 1k
.end
