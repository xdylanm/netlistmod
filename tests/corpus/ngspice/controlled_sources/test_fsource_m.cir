.title KiCad schematic
* variant: half the gain with m=2 (manual 4.2.3)
.op
.control
  run
  print v(/VX) v(/OUT)
.endc
.param K=2.2
R1 /OUT GND 1k
F1 /OUT GND V1 {K/2} m=2
V1 Net-_R5-Pad1_ GND DC 2
R5 Net-_R5-Pad1_ /VX 1k
R6 /VX GND 1k
.end
