.title KiCad schematic
* variant: a parameter in braces inside a bare expression
.op
.control
  run
  print v(/VX) v(/OUT)
.endc
R1 /OUT GND 1k
R5 Net-_R5-Pad1_ /VX 1k
V1 Net-_R5-Pad1_ GND DC 2
R6 /VX GND 1k
.param K=2
B1 /OUT GND V={K}*v(/VX)
.end
