.title KiCad schematic
* variant: a bare expression with blanks, then tc1= (manual 5.1)
.op
.control
  run
  print v(/VX) v(/OUT)
.endc
R1 /OUT GND 1k
R5 Net-_R5-Pad1_ /VX 1k
V1 Net-_R5-Pad1_ GND DC 2
R6 /VX GND 1k
B1 /OUT GND V = 2 * v(/VX) tc1=0
.end
