M8 LTspice sources and diodes
V1 a 0 3
V2 b 0 DC 3
V3 c 0 3 AC 1
V4 e 0 3 AC=1 45
V5 f 0 DC 3 AC 1 45 Rser=1 Cpar=1p
V6 g 0 2k2 Rser=1k5
V7 h 0
I1 0 i 1m
I2 0 j DC 1m AC 1
I3 0 k 1m load
I4 0 l R=1k
I5 0 m AC 1 45
R1 a 0 1k
R2 b 0 1k
R3 c 0 1k
R4 e 0 1k
R5 f 0 1k
R6 g 0 1k
R7 h 0 1k
R8 i 0 1k
R9 j 0 1k
R10 k 0 1k
R11 l 0 1k
R12 m 0 1k
D1 a n dm
D2 n 0 dm 2
D3 a o dm off
R13 o 0 1k
D4 a p dm 2 off m=2 n=2 temp=30
R14 p 0 1k
.model dm D(Is=1e-14)
.op
.end
