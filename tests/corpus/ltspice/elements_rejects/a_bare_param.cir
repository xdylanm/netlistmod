M17 reject
A1 a 0 0 0 0 b 0 0 BUF Vhigh=x
.end
