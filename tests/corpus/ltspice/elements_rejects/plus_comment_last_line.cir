M18 reject
V1 a 0 1
R1 a 0 1k
+ ; a comment-only last line
.op
.end
