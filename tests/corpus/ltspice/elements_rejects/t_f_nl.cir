M16 reject
T1 a 0 b 0 Zo=50 F=100meg NL=0.25
.end
