* lt_test_esource.asc
* reject: ngspice's TABLE form, which LTspice runs but its reference does not show
* Generated by LTspice 26.1.1 for Windows.
E1 OUT N002 TABLE {V(VX)} = (0,0) (2,4.4)
R1 OUT 0 1k
R2 N001 VX 1k
R3 VX 0 1k
R4 N002 0 100
V1 N001 0 2
.op
.backanno
.end
