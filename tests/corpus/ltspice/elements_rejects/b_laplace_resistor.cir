* lt_test_fsource.asc
* reject: laplace= on R=; LTspice runs it, but its reference shows it on V= and I= only (decision 0017 item 4)
* Generated by LTspice 26.1.1 for Windows.
R1 OUT 0 1k
R2 N001 VX 1k
R3 VX 0 1k
V1 N001 0 2
B1 OUT 0 R=1k laplace=1/(1+s/1k)
.op
.param K=2.2
.backanno
.end
