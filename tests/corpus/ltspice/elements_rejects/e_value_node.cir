* lt_test_esource.asc
* reject: value after the output nodes is the keyword, not the node; LTspice stops
* Generated by LTspice 26.1.1 for Windows.
E1 OUT N002 value 0 2.2
Rv value 0 1k
R1 OUT 0 1k
R2 N001 VX 1k
R3 VX 0 1k
R4 N002 0 100
V1 N001 0 2
.op
.backanno
.end
