* lt_test_fsource.asc
* reject: value after the output nodes is the keyword, not the source; LTspice runs it as value=
* Generated by LTspice 26.1.1 for Windows.
R1 OUT 0 1k
R2 N001 VX 1k
R3 VX 0 1k
V1 N002 0 2
value N001 N002 0
F1 OUT 0 value 2.2
.op
.param K=2.2
.backanno
.end
