M16 reject
T1 a 0 b 0 Zo=50 Td=1n IC=0,0,0,0
.end
