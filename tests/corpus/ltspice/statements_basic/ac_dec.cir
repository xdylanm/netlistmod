M8 LTspice AC range
V1 in 0 1 AC 1
R1 in out 1k
C1 out 0 1n
.ac dec 10 1 1k5
.end
