M8 LTspice .noise (untyped) and .temp with a list
V1 in 0 1 AC 1
R1 in out 1k
.noise V(out) V1 dec 1 1 10
.temp 27 30
.end
