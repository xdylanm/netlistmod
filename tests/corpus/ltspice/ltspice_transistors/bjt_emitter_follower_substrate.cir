* bjt_emitter_follower.net with the PNP substrate on the supply
* Generated by LTspice 26.1.1 for Windows.
V2 IN 0 SIN(2.5 1 100k 0 0 0) AC 1
R1 N003 IN 10k
V1 N001 0 5
R2 N001 N002 1k
Q2 0 N003 N002 N001 BC557B_OJ
Q1 N001 N002 OUT 0 BC547B_OJ
R3 OUT 0 1k
.include jellybean.lib
.op
.tran 100n 30u
.backanno
.end
