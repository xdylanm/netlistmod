* cmos_discrete_xor.net with VDMOS m= and off
* Generated by LTspice 26.1.1 for Windows.
MQ8 Q4_D Q1_D OUT OUT 2N7000_OJ m=2
MQ4 Q4_D Q1_D B B 2N7000_OJ
MQ2 Q1_D A Q2_S Q2_S BS250_OJ
MQ3 B A Q3_S Q3_S BS250_OJ
MQ7 OUT A Q3_S Q3_S BS250_OJ
R1 Q2_S R1_Pad2 10
V1 R1_Pad2 0 5
MQ1 Q1_D A 0 0 2N7000_OJ off
MQ9 Q5_D B A A BS250_OJ
MQ5 Q5_D B OUT OUT BS250_OJ
V2 A 0 PULSE(0 5 2n 20n 20n 250n 500n)
V3 B 0 PULSE(0 5 2n 20n 20n 500n 1u)
C1 OUT 0 220p
MQ6 OUT B Q10_S Q10_S 2N7000_OJ
R2 0 OUT 100k
MQ10 Q1_D B Q10_S Q10_S 2N7000_OJ
.include jellybean.lib
.tran 1n 4u
.backanno
.end
