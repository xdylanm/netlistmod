* cmos_discrete_xor.net with its models copied from openjellybean 0.5.0, BS250_OJ with pchan
* Generated by LTspice 26.1.1 for Windows.
MQ8 Q4_D Q1_D OUT OUT 2N7000_OJ
MQ4 Q4_D Q1_D B B 2N7000_OJ
MQ2 Q1_D A Q2_S Q2_S BS250_OJ
MQ3 B A Q3_S Q3_S BS250_OJ
MQ7 OUT A Q3_S Q3_S BS250_OJ
R1 Q2_S R1_Pad2 10
V1 R1_Pad2 0 5
MQ1 Q1_D A 0 0 2N7000_OJ
MQ9 Q5_D B A A BS250_OJ
MQ5 Q5_D B OUT OUT BS250_OJ
V2 A 0 PULSE(0 5 2n 20n 20n 250n 500n)
V3 B 0 PULSE(0 5 2n 20n 20n 500n 1u)
C1 OUT 0 220p
MQ6 OUT B Q10_S Q10_S 2N7000_OJ
R2 0 OUT 100k
MQ10 Q1_D B Q10_S Q10_S 2N7000_OJ
* 2N7000_OJ: copied from openjellybean 0.5.0 (https://github.com/xdylanm/openjellybean), MIT;
* Copyright (c) 2026 openjellybean contributors.
.model 2N7000_OJ VDMOS(VTO=2.0 KP=0.3 LAMBDA=0.01 RD=0.6 RS=0.1 RG=10
+ CGS=16p CGDMAX=20p CGDMIN=3p A=0.5
+ CJO=40p VJ=0.75 M=0.5 IS=1e-13 N=1.1 RB=0.2 BV=60 IBV=10u TT=20n)
* BS250_OJ: copied from openjellybean 0.5.0 (https://github.com/xdylanm/openjellybean), MIT;
* Copyright (c) 2026 openjellybean contributors.
.model BS250_OJ VDMOS(pchan VTO=-2.1 KP=0.02 LAMBDA=0.01 RD=1.8 RS=0.2 RG=10
+ CGS=25p CGDMAX=21p CGDMIN=3.7p A=0.5
+ CJO=57p VJ=0.75 M=0.5 IS=1e-13 N=1.1 RB=0.5 BV=45 IBV=10u TT=30n)
.tran 1n 4u
.backanno
.end
