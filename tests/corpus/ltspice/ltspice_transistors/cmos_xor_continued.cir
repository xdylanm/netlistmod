* cmos_xor.net with the parameters on + continuation lines
* Generated by LTspice 26.1.1 for Windows.
M1 N001 B 0 0 NMOS_L8
+ l=1u w=10u
+ m=2
M2 VCC B N001 VCC PMOS_L8
+ l=1u w=10u
+ m=2
V1 VCC 0 3.3
M3 A B OUT VCC PMOS_L8
+ l=1u w=10u
+ m=2
M4 B A OUT VCC PMOS_L8
+ l=1u w=10u
+ m=2
M5 OUT N001 A 0 NMOS_L8
+ l=1u w=10u
+ m=2
M6 OUT A N001 0 NMOS_L8
+ l=1u w=10u
+ m=2
V2 B 0 PULSE(0 3.3 2n 2n 2n 250n 500n) AC 1
V3 A 0 PULSE(0 3.3 2n 2n 2n 500n 1u) AC 1
R1 OUT 0 100k
C1 OUT 0 22p
.tran 0 4u 0 1n
.model NMOS_L8 NMOS level=8
.model PMOS_L8 PMOS level=8
.backanno
.end
