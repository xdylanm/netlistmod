M8 reject
.dc V1 0 1 1 V2 0 1 1 V3 0 1 1 V4 0 1 1
.end
