M8 reject
.subckt s a
.four 1k V(a)
.ends
.end
