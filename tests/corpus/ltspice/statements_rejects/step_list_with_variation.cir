M8 reject
.step lin param x list 1 2
.end
