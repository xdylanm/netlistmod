M8 reject
.machine
.state a 0
.endmachine
.end
