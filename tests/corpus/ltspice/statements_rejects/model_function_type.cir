M18 reject
.model mybuf BUF(Vhigh=5)
.end
