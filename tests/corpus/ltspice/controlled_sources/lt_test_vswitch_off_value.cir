* lt_test_vswitch.asc
* variant: a flag with a value, as LTspice's Element Overview allows
* Generated by LTspice 26.1.1 for Windows.
R1 N001 OUT 1k
R2 N002 VX 1k
R3 VX 0 1k
V1 N002 0 2
S1 0 OUT VX 0 a_switch off=1
V2 N001 0 4
.model a_switch SW vt=0.9 vh=0.3 ron=1 roff=1Meg
.dc V1 0 3 0.5
.backanno
.end
