* lt_test_fsource.asc
* variant: B with P= and vprx=
* Generated by LTspice 26.1.1 for Windows.
R1 OUT 0 1k
R2 N001 VX 1k
R3 VX 0 1k
V1 N001 0 2
B1 OUT 0 P=1m*V(VX) vprx=1
.op
.param K=2.2
.backanno
.end
