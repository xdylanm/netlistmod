* lt_test_fsource.asc
* variant: value=
* Generated by LTspice 26.1.1 for Windows.
R1 OUT 0 1k
R2 N001 VX 1k
R3 VX 0 1k
V1 N001 0 2
F1 OUT 0 value={-K*I(V1)}
.op
.param K=2.2
.backanno
.end
