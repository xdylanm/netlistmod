* lt_test_fsource.asc
* variant: B with laplace=, window= and nfft=
* Generated by LTspice 26.1.1 for Windows.
R1 OUT 0 1k
R2 N001 VX 1k
R3 VX 0 1k
V1 N001 0 2
B1 OUT 0 V=K*V(VX) laplace=1/(1+s/1k) window=1m nfft=1024
.op
.param K=2.2
.backanno
.end
