* lt_test_fsource.asc
* variant: the controlling source is an E; both solvers run it, the references name a V
* Generated by LTspice 26.1.1 for Windows.
R1 OUT 0 1k
R2 N001 VX 1k
R3 VX 0 1k
V1 N001 0 2
E2 N003 0 VX 0 1
R9 N003 0 1k
F1 OUT 0 E2 {K}
.op
.param K=2.2
.backanno
.end
