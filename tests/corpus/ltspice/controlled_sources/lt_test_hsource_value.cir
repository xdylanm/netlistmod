* lt_test_hsource.asc
* variant: value=
* Generated by LTspice 26.1.1 for Windows.
R1 OUT 0 1k
R2 N001 VX 1k
R3 VX 0 1k
V1 N001 0 2
H1 OUT 0 value={-2.2k*I(V1)}
.op
.backanno
.end
