* lt_test_fsource.asc
* variant: B reading the current through V1
* Generated by LTspice 26.1.1 for Windows.
R1 OUT 0 1k
R2 N001 VX 1k
R3 VX 0 1k
V1 N001 0 2
B1 OUT 0 V=-K*1k*I(V1)
.op
.param K=2.2
.backanno
.end
