* lt_test_hsource.asc
* variant: the controlling source is inside an instance (X1:Vq); LTspice runs it
* Generated by LTspice 26.1.1 for Windows.
R1 OUT 0 1k
R2 N001 VX 1k
R3 VX 0 1k
V1 N001 0 2
X1 VX sense
H1 OUT 0 X1:Vq 1k
.subckt sense a
Vq a b 0
Rq b 0 1k
.ends
.op
.backanno
.end
