* lt_test_esource.asc
* variant: POLY(1)
* Generated by LTspice 26.1.1 for Windows.
E1 OUT N002 POLY(1) VX 0 0 2.2
R1 OUT 0 1k
R2 N001 VX 1k
R3 VX 0 1k
R4 N002 0 100
V1 N001 0 2
.op
.backanno
.end
