* lt_test_gsource.asc
* variant: the transconductance is a formula
* Generated by LTspice 26.1.1 for Windows.
R1 OUT 0 1k
R2 N001 VX 1k
R3 VX 0 1k
V1 N001 0 2
R4 N001 VX2 1.5k
R6 VX2 0 470
G1 OUT 0 VX VX2 {-gm}
.param gm=1.94m
.op
.backanno
.end
