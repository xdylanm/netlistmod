* lt_test_esource.asc
* variant: an L with Flux= (x is its current)
* Generated by LTspice 26.1.1 for Windows.
E1 OUT N002 VX 0 2.2
R1 OUT 0 1k
L9 OUT N9 Flux=1m*tanh(5*x)
R9 N9 0 1k
R2 N001 VX 1k
R3 VX 0 1k
R4 N002 0 100
V1 N001 0 2
.op
.backanno
.end
