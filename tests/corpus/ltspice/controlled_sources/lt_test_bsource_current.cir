* lt_test_fsource.asc
* variant: B with I= and Rpar=
* Generated by LTspice 26.1.1 for Windows.
R1 OUT 0 1k
R2 N001 VX 1k
R3 VX 0 1k
V1 N001 0 2
B1 0 OUT I=K*1m*V(VX) Rpar=1Meg
.op
.param K=2.2
.backanno
.end
