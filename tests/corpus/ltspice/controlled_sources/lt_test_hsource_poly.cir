* lt_test_hsource.asc
* variant: POLY(1)
* Generated by LTspice 26.1.1 for Windows.
R1 OUT 0 1k
R2 N001 VX 1k
R3 VX 0 1k
V1 N001 0 2
H1 OUT 0 POLY(1) V1 0 -2.2k
.op
.backanno
.end
