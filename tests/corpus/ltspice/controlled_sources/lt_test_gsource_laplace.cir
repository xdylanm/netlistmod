* lt_test_gsource.asc
* variant: Laplace= with window=, nfft= and mtol=
* Generated by LTspice 26.1.1 for Windows.
R1 OUT 0 1k
R2 N001 VX 1k
R3 VX 0 1k
V1 N001 0 2
R4 N001 VX2 1.5k
R6 VX2 0 470
G1 OUT 0 VX VX2 Laplace=-gm/(1+s/1k) window=1m nfft=1024 mtol=1
.param gm=1.94m
.op
.backanno
.end
