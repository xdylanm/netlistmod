* test_ltspice_fra_flist.cir: test_ltspice_fra.net with flist= listing its frequencies with blanks, over a + line
* Generated by LTspice 26.1.1 for Windows.
R1 N001 N003 10k
R2 N002 N001 10k
C1 N002 N001 1n
V1 N003 0 0 AC 1
R3 N004 0 100k
@1 N004 N002 delay=1m fstart=1k fend=100k flist=1k 10k
+ 100k tavgmin=1m tsettle=0.5m
&1 N004 0 N001 0
X§U2 0 N001 VCC VEE N004 TL07X_OJ ;§pnba In+)In-)V+)V-)OUT
V2 VCC 0 12
V3 0 VEE 12
.fra
.lib jellybean.lib
.backanno
.end
