* test_ltspice_gates_params.cir: test_ltspice_gates.net with lower-case function names, a comma between parameters and a braced value
* Generated by LTspice 26.1.1 for Windows.
A1 N007 0 0 0 0 N008 N005 0 buf
A2 N008 0 0 0 0 N009 0 0 BUF td=13n
A3 N005 0 0 0 0 0 N006 0 BUF trise=8n
A4 N003 N001 N006 N003 N003 N011 N004 0 and vhigh={vh}, trise=8n
.param vh=3.3
A5 N004 0 N009 0 0 N010 N001 0 OR
A6 0 0 N010 N011 N009 N012 0 0 XOR
V1 N013 0 PULSE(0 5 0 10n 10n 100n 200n) AC 1
R1 N014 N013 50
A7 N012 0 N014 0 0 N002 0 0 DFLOP
V2 N007 0 PULSE(0 5 30n 10n 10n 580n 970n)
A8 N001 N002 0 0 0 0 0 0 SRFLOP
V3 N003 0 3.3
.tran 2u
.backanno
.end
