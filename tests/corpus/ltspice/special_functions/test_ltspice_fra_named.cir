* test_ltspice_fra_named.cir: test_ltspice_fra.net with the analyzer and its probe named @A and &a
* Generated by LTspice 26.1.1 for Windows.
R1 N001 N003 10k
R2 N002 N001 10k
C1 N002 N001 1n
V1 N003 0 0 AC 1
R3 N004 0 100k
@A N004 N002 delay=1m fstart=1k fend=100k oct=1 tavgmin=1m tsettle=0.5m
&a N004 0 N001 0
X§U2 0 N001 VCC VEE N004 TL07X_OJ ;§pnba In+)In-)V+)V-)OUT
V2 VCC 0 12
V3 0 VEE 12
.fra
.lib jellybean.lib
.backanno
.end
