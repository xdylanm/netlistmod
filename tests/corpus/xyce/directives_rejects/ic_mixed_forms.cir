both forms on one .IC
V1 in 0 2 AC 1
R1 in out 1k
R2 out 0 1k
C1 out 0 1n
.ic v(out)=0.5 in 2
.end
