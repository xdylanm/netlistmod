two sweeps on one .STEP
V1 in 0 2 AC 1
R1 in out 1k
R2 out 0 1k
C1 out 0 1n
.step R1 1k 2k 1k R2 1k 2k 1k
.end
