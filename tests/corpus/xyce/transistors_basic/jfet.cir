xyce JFETs and MESFETs: the J and Z lines of X-M4
VD d 0 5
VG g 0 0
J1 d g 0 jn
J2 d g 0 jn 2 temp=50
J3 d g 0 jp area=2 dtemp=5
J4 d g 0 jn2 {2}
Z1 d g 0 zn
Z2 d g 0 zn 2
Z3 d g 0 zp area=2 temp=30
.MODEL jn njf
.MODEL jp pjf
.MODEL jn2 njf level=2
.MODEL zn nmf vto=-1
.MODEL zp pmf
.END
