reject: a double quote in a node name
V1 a 0 1
R1 a b"c 1k
R2 b"c 0 1k
.END
