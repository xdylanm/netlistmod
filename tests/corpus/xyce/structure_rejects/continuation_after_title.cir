reject: + right after the title
+ R1 a 0 1k
V1 a 0 1
.END
