reject: // is not a comment
V1 a 0 1
R1 a 0 1k // load
.END
