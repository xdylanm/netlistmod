reject: .options is X-M2 B3's
V1 a 0 1
R1 a 0 1k
.options timeint method=gear
.END
