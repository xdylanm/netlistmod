reject: .tran is X-M2's
V1 a 0 1
R1 a 0 1k
.tran 1n 10n
.END
