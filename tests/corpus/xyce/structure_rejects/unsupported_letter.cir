reject: T is X-M6's
V1 c 0 1
R1 b 0 50
T1 c 0 b 0 Z0=50 TD=1n
.END
