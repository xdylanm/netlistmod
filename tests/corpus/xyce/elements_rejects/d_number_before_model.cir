reject: a number before D's model
.model dm D
V1 a 0 1
R1 a b 1k
D1 b 0 2 dm
.END
