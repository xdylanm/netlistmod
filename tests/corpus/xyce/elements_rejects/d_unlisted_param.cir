reject: an unknown D parameter
.model dm D
V1 a 0 1
R1 a b 1k
D1 b 0 dm rs=1
.END
