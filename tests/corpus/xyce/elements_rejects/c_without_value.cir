reject: C without a value, charge or length
V1 a 0 1
R1 a 0 1k
C1 a 0
.END
