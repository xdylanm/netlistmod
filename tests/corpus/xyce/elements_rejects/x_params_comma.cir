reject: a comma in an X line's PARAMS:
.subckt s a params: r=1k
R1 a 0 {r}
.ends
V1 n 0 1
X1 n s params: r=2k, m=1
.END
