reject: R's value twice
V1 a 0 1
R1 a 0 1k R=2k
.END
