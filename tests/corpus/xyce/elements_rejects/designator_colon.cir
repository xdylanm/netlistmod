reject: a colon in a designator
.subckt s a
R1 a 0 1k
.ends
V1 n 0 1
X1:y n s
.END
