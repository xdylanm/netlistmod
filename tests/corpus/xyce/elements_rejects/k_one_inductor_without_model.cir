reject: one inductor and no model
V1 a 0 1
R1 a b 1k
L1 b 0 1u
K1 L1 1
.END
