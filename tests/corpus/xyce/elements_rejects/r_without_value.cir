reject: R without a value
V1 a 0 1
R1 a 0
.END
