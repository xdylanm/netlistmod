reject: .GLOBAL_PARAM in a body
.subckt s a
.global_param g=1
R1 a 0 1k
.ends
V1 n 0 1
X1 n s
.END
