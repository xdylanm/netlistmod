reject: .ENDL names another entry
.lib first
R9 a 0 1k
.endl second
V1 n 0 1
R1 n 0 1k
.END
