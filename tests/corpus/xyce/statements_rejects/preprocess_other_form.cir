reject: the other .PREPROCESS forms are not read
.preprocess removeunused c
V1 n 0 1
R1 n 0 1k
.END
