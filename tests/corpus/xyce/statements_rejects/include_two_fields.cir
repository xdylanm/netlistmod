reject: a second field on .INCLUDE
.include one.inc two.inc
V1 n 0 1
R1 n 0 1k
.END
