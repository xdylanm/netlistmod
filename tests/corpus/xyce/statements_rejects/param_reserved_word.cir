reject: a reserved word as a parameter
.param temp=1
V1 n 0 1
R1 n 0 1k
.END
