subcircuits and models
.model rpoly R (R=1 TC1=1m)
.model rsheet RES RSH=50
.model dfast D (IS=1e-14 N=1.05)
.model cstd CAP C=1
.model lstd IND (L=1)
.model nch.1 NMOS (LEVEL=1)
.subckt divider top bot PARAMS: ra=1k rb=1k
Ra top mid {ra}
Rb mid bot {rb}
.param rinner={ra*10}
.subckt inner p q
Rinner p q 10k
.ends inner
Xin mid bot inner
.ends divider
.subckt bias out
+ params: level=1
Rb out 0 {level*1k}
.ends
V1 1 0 2
X1 1 0 divider PARAMS: ra=2k rb={3k}
X2 1 0 divider ra=1k M=2
X3 1 bias
R1 1 2 rpoly 1k
R2 2 0 rsheet L=20u W=2u
C1 2 0 cstd 1p
L1 2 3 lstd 1u
R3 3 0 1k
D1 2 0 dfast
.END
