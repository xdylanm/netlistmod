reject: a 6th Q node
VC c 0 5
VB b 0 0.7
V4 n4 0 0
V5 n5 0 0
V6 n6 0 0
Q1 c b 0 n4 n5 n6 qv
.MODEL qv npn level=12
.END
