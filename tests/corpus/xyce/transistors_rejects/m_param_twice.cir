reject: W= written twice
VD d 0 1
VG g 0 2
M1 d g 0 0 nm W=10u W=20u
.MODEL nm nmos level=1
.END
