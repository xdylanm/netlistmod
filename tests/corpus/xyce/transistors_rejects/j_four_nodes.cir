reject: a 4th J node
VD d 0 5
VG g 0 0
J1 d g 0 x jm
.MODEL jm njf
.END
