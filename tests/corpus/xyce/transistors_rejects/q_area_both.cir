reject: a positional area and area=
VC c 0 5
VB b 0 0.7
Q1 c b 0 qn 2 area=3
.MODEL qn npn
.END
