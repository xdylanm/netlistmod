reject: SIN takes 3 to 6 arguments
V1 1 0 SIN(0 1)
R1 1 0 1k
.END
