reject: PAT's DATA is a bit string
V1 1 0 PAT(5 0 0 1n 1n 5n 010)
R1 1 0 1k
.END
